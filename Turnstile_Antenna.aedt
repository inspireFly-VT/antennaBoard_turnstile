# Ansys Electronics Desktop project, version 2025.1
materials:
  vacuum: permittivity=1
  copper: permeability=0.999991 conductivity=58000000

design HFSSDesign1 (HFSS, HFSS Hybrid Terminal Network, model units mm)
variables:
  z_offset = 0.6mm
  ysize = -1mm
  zsize = 1mm
  xsize = -1mm
geometry:
  DipoleX_1 [copper] = cylinder(axis=X, base_centre=(0.5mm, 0mm, zsize+z_offset/6), radius=0.5mm, height=169mm)
  DipoleX_2 [copper] = cylinder(axis=X, base_centre=(-169mm, 0mm, zsize+z_offset/6), radius=0.5mm, height=168.5mm)
  DipoleY_1 [copper] = cylinder(axis=Y, base_centre=(0mm, 0.5mm, 0mm), radius=0.5mm, height=169mm)
  DipoleY_2 [copper] = cylinder(axis=Y, base_centre=(0mm, -169mm, 0mm), radius=0.5mm, height=168.5mm)
  XPort = rectangle(corner=(0mm, -ysize/2, -zsize/2), y_size=ysize, z_size=zsize)
  YPort = rectangle(corner=(-xsize/2, 0mm, z_offset), z_size=zsize, x_size=xsize)
  RadiatingSurface [vacuum] = region(absolute_offset=232.55814mm on all sides)
boundaries and excitations:
  Open1: Radiation Objects=RadiatingSurface
  XPort_T1: Terminal port=1 Edges=XPort.edge(at (0, 0.5, 0), at (0, 0, -0.5), at (0, 0, 0.5)) TerminalResistance=50ohm
  YPort_T1: Terminal port=2 Edges=YPort.edge(at (0.5, 0, 1.1), at (0, 0, 0.6)) TerminalResistance=50ohm
  1: Lumped Port Faces=XPort.face LumpedPortType=Terminal Impedance=50ohm
  2: Lumped Port Faces=YPort.face LumpedPortType=Terminal Impedance=50ohm
setups:
  Setup1: HfssDriven Frequency=430MHz MaxDeltaS=0.02 MaximumPasses=5 MinimumPasses=1 MinimumConvergedPasses=1 PercentRefinement=30 BasisOrder=1 PortAccuracy=2 DrivenSolverType="Direct Solver"
    sweep Sweep: 215MHz to 645MHz, 201 points; Type=Interpolating InterpTolerance=0.5 InterpMaxSolns=250 PassivityErrorTolerance=0.0001
source amplitudes:
  1:1: 1V 0deg
  2:1: 0V 0deg
radiation setups:
  3D: Infinite Sphere Theta=-180deg..180deg step 2deg Phi=-180deg..180deg step 2deg
  Elevation: Infinite Sphere Theta=-180deg..180deg step 1deg Phi=0deg..90deg step 90deg
  Azimuth: Infinite Sphere Theta=90deg..90deg step 0deg Phi=-180deg..180deg step 1deg
reports:
  Terminal S Parameter Plot1: dB(St(XPort_T1,XPort_T1)) vs Freq on Setup1 : Sweep
  Axial Ratio Plot1: dB(AxialRatioValue) vs Theta on Setup1 : LastAdaptive, 3D [Phi=-90deg Freq=0.43GHz]; markers m1 at 90deg
  Gain Plot4: dB(GainLHCP), dB(GainRHCP) vs Theta on Setup1 : LastAdaptive, 3D [Phi=90deg Freq=0.43GHz]
  Gain Plot5: dB(GainTotal) vs Phi, Theta on Setup1 : LastAdaptive, 3D [Freq=0.43GHz]
