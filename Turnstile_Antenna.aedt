# Ansys Electronics Desktop project, version 2025.2
materials:
  vacuum: permittivity=1
  copper: permeability=0.999991 conductivity=58000000

design HFSSDesign1 (HFSS, HFSS Terminal Network, model units mm)
geometry:
  DipoleX_1 [copper] = cylinder(axis=X, base_centre=(0.5mm, 0mm, 0mm), radius=0.5mm, height=169mm)
  DipoleX_2 [copper] = cylinder(axis=X, base_centre=(-169mm, 0mm, 0mm), radius=0.5mm, height=168.5mm)
  DipoleY_1 [copper] = cylinder(axis=Y, base_centre=(0mm, 0.5mm, 0mm), radius=0.5mm, height=169mm)
  DipoleY_2 [copper] = cylinder(axis=Y, base_centre=(0mm, -169mm, 0mm), radius=0.5mm, height=168.5mm)
  XSheet = rectangle(corner=(0mm, 0.5mm, -0.5mm), y_size=-1.05mm, z_size=1mm)
  YPort = rectangle(corner=(0.5mm, 0mm, -0.5mm), z_size=1.1mm, x_size=-1.1mm)
  RAD_box [vacuum] = box(corner=(-400mm, -400mm, -150mm), size=(800mm, 800mm, 300mm))
boundaries and excitations:
  Rad1: Radiation Objects=RAD_box
  Port2: Lumped Port Objects=XSheet LumpedPortType=Modal Modes{Mode1{IntLine{(0, -0.55, 0) -> (0, 0.5, 0)} CharImp=Zpi}} Impedance=50ohm
  Port1: Lumped Port Objects=YPort LumpedPortType=Modal Modes{Mode1{IntLine{(0.5, 0, 0.05) -> (-0.6, 0, 0.05)} CharImp=Zpi}} Impedance=50ohm
setups:
  Setup1: HfssDrivenAuto AutoSolverSetting=Balanced Type=Discrete
    sweep Sweep: 430MHz to 430MHz, 300 points;
source amplitudes:
  Port2:1: 1W 90deg
  Port1:1: 1W 0deg
radiation setups:
  Infinite Sphere1: Infinite Sphere Theta=-180deg..180deg step 2deg Phi=-180deg..180deg step 2deg
field plots:
  Mag_E1: E Field over DipoleX_1.face(all 3) on Setup1 : LastAdaptive at Freq=0.43GHz Phase=0deg
  Mag_E2: E Field over DipoleX_2.face(all 3) on Setup1 : LastAdaptive at Freq=0.43GHz Phase=0deg
  Mag_E3: E Field over DipoleY_1.face(all 3) on Setup1 : LastAdaptive at Freq=0.43GHz Phase=0deg
  Mag_E4: E Field over DipoleY_2.face(all 3) on Setup1 : LastAdaptive at Freq=0.43GHz Phase=0deg
reports:
  S Parameter Plot1: dB(S(Port1,Port1)) vs Freq on Setup1 : Sweep
